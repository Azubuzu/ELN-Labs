# Ansys Electronics Desktop project, version 2017.1
materials:
  copper: permeability=0.999991 conductivity=58000000

design ex3 (Circuit)
options: SParamCircuitDef IntegrationMethod=FFT
components:
  A3 = MS_TRL(W=0.019961m P=0.002536m)
  A1 = MS_TRL(W=0.019961m P=0.002536m)
  A2 = MS_TRL(W=0.000256m P=0.005974m)
  A4 = MS_TRL(W=0.000256m P=0.005974m)
  A5 = MS_TRL(W=0.019961m P=0.01026m)
  A6 = MS_TRL(W=0.019961m P=0.01026m)
  A7 = MS_TRL(W=0.000256m P=0.009582m)
  port Port1 pnum=1 rz=50ohm iz=0ohm noisetemp=16.85 noisetemporig=16.85cel
  port Port2 pnum=2 rz=50ohm iz=0ohm
nets:
  net_12: A3.1, A2.1
  net_13: A2.0, A5.1
  net_14: A5.0, A7.1
  net_15: A6.1, A7.0
  net_16: A1.1, A4.0
  net_18: A4.1, A6.0
  Port1: A3.0
  Port2: A1.0
setups:
  LinearFrequency: LinearFrequencyData(false, 0.1, false, "", false) SweepDefinition{Variable=F Data="LINC 0.3GHz 10GHz 1001"}
reports:
  S Parameter Plot 1: dB(S(Port1,Port2)) vs F on LinearFrequency : LinearFrequency

design ex4 (Circuit)
options: SParamCircuitDef IntegrationMethod=FFT
components:
  A7 = MS_TRL(W=0.256 P=9.582)
  A6 = MS_TRL(W=19.961 P=10.26)
  A5 = MS_TRL(W=19.961 P=10.26)
  port Port1 pnum=2 rz=50ohm iz=0ohm noisetemp=16.85 noisetemporig=16.85cel
  port Port2 pnum=1 rz=50ohm iz=0ohm
nets:
  net_12: A7.0, A6.1
  net_13: A5.0, A7.1
  Port1: A5.1
  Port2: A6.0
