# Ansys Electronics Desktop project, version 2017.1
materials:
  copper: permeability=0.999991 conductivity=58000000
  FR4_epoxy: permittivity=4.4 dielectric_loss_tangent=0.02

design Capacitor_0805_sim (Circuit)
options: SParamCircuitDef IntegrationMethod=FFT
components:
  C1 = CAP_(C=1e-010farad)
  L3 = IND_(L=1.86e-009)
  R5 = RES_(R=0.163)
  port Port1 pnum=1 rz=50ohm iz=0ohm
  port Port2 pnum=2 rz=50ohm iz=0ohm
nets:
  0: C1.1
  net_2: L3.1, R5.0
  net_7: C1.0, R5.1
  Port1: port Port2, L3.0
setups:
  LinearFrequency: LinearFrequencyData(false, 0.1, false, "", false) SweepDefinition{Variable=F Data="LINC 100MHz 1GHz 100"}
reports:
  S Parameter Plot 2: dB(S(Port2,Port1)) vs F on LinearFrequency : LinearFrequency; dB(S(Port2,Port1)) vs F; markers m1 at 0.37272727GHz

design Inductor_3.3u_sim (Circuit)
options: SParamCircuitDef IntegrationMethod=FFT
components:
  L10 = IND_(L=3.3e-006)
  C11 = CAP_()
  A12 = NXCHIPRES()
  port Port1 pnum=1 rz=50ohm iz=0ohm
  port Port2 pnum=2 rz=50ohm iz=0ohm
nets:
  net_2: L10.1, A12.0
  Port1: L10.0, C11.0
  Port2: C11.1, A12.1
setups:
  Ind_33: LinearFrequencyData(false, 0.1, false, "", false) SweepDefinition{Variable=F Data="LINC 50MHz 1GHz 10 LINC 10MHz 100MHz 10 LINC 100MHz 1GHz 10 LINC 10MHz 100MHz 10"}

design Capacitor_0603_sim (Circuit)
options: SParamCircuitDef IntegrationMethod=FFT
components:
  R5 = RES_(R=0.163)
  L3 = IND_(L=1.86e-009)
  C1 = CAP_(C=1e-010farad)
  port Port3 pnum=3 rz=50ohm iz=0ohm
  port Port4 pnum=4 rz=50ohm iz=0ohm
nets:
  0: C1.1
  net_7: R5.1, C1.0
  net_8: R5.0, L3.1
  Port3: port Port4, L3.0
setups:
  LinearFrequency: LinearFrequencyData(false, 0.1, false, "", false) SweepDefinition{Variable=F Data="LINC 100MHz 1GHz 1000"}
reports:
  S Parameter Plot 1: dB(S(Port2,Port1)) vs F on LinearFrequency : LinearFrequency; dB(S(Port2,Port1)) vs F

design Inductor_100n_sim (Circuit)
options: SParamCircuitDef IntegrationMethod=FFT
components:
  L10 = IND_(L=1e-007)
  C11 = CAP_()
  A12 = NXCHIPRES()
  port Port1 pnum=1 rz=50ohm iz=0ohm
  port Port2 pnum=2 rz=50ohm iz=0ohm
nets:
  net_2: L10.1, A12.0
  Port1: L10.0, C11.0
  Port2: C11.1, A12.1
setups:
  Ind_100: LinearFrequencyData(false, 0.1, false, "", false) SweepDefinition{Variable=F Data="LINC 50MHz 1GHz 10 LINC 10MHz 100MHz 10 LINC 100MHz 1GHz 10 LINC 10MHz 100MHz 10 LINC 500MHz 1.5GHz 10"}

design Capacitor_0805_mes (Circuit)
options: SParamCircuitDef IntegrationMethod=FFT
components:
  S45 = TOUCHSTONE2()
  port Port1 pnum=1 rz=50ohm iz=0ohm
  port Port2 pnum=2 rz=50ohm iz=0ohm
nets:
  Port1: S45.0
  Port2: S45.1
setups:
  LinearFrequency: LinearFrequencyData(false, 0.1, false, "", false) SweepDefinition{Variable=F Data="LINC 100MHz 1GHz 1000"}
reports:
  S Parameter Plot 1: dB(S(Port2,Port1)) vs F on LinearFrequency : LinearFrequency; markers m1 at 0.37657658GHz

design Capacitor_0603_mes (Circuit)
options: SParamCircuitDef IntegrationMethod=FFT
components:
  S47 = TOUCHSTONE3()
  port Port1 pnum=1 rz=50ohm iz=0ohm
  port Port2 pnum=2 rz=50ohm iz=0ohm
nets:
  Port1: S47.0
  Port2: S47.1
setups:
  LinearFrequency: LinearFrequencyData(false, 0.1, false, "", false) SweepDefinition{Variable=F Data="LINC 100MHz 1GHz 1000"}
reports:
  S Parameter Plot 1: dB(S(Port2,Port1)) vs F on LinearFrequency : LinearFrequency
