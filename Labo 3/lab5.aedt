# Ansys Electronics Desktop project, version 2017.1
materials:
  copper: permeability=0.999991 conductivity=58000000

design Circuit1 (Circuit)
options: SParamCircuitDef IntegrationMethod=FFT
components:
  A3 = MS_TRL(W=19.961 P=2.536)
  A1 = MS_TRL(W=19.961 P=2.536)
  A2 = MS_TRL(W=0.256 P=5.974)
  A4 = MS_TRL(W=0.256 P=5.974)
  A5 = MS_TRL(W=19.961 P=10.26)
  A6 = MS_TRL(W=19.961 P=10.26)
  A7 = MS_TRL(W=0.256 P=9.582)
nets:
  0: A3.0, A1.0, A5.0, A6.0
  net_1: A3.1, A2.1
  net_2: A1.1, A4.0
  net_3: A2.0, A5.1, A7.1
  net_4: A4.1, A6.1, A7.0
