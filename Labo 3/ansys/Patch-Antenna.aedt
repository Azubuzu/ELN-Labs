# Ansys Electronics Desktop project, version 2017.1
materials:
  air: permittivity=1.0006 permeability=1.0000004
  copper: permeability=0.999991 conductivity=58000000
  FR4_epoxy: permittivity=4.4 dielectric_loss_tangent=0.02
  pec: conductivity=1e+030
  vacuum: permittivity=1

design EMDesign1 (HFSS 3D Layout)
variables:
  W = 37.6mm
  L = 28.45mm
  h = 1.5mm
  line_w = 1.21mm
  line_l = 17.52mm
  pcb_l = 160mm
  pcb_w = 100mm
  line2_w = 2.82mm
  V_offset = 30mm
  H_offset = 150mm
ports:
  Port1: Properties{Reference=Ground Impedance=50ohm Magnitude=1V Phase=0deg PostProcess Renormalize="50ohm + 0i ohm" Deembed=0mm Type="Single Strip Gap Source" HFSS_Type=Gap Orientation=Vertical Layer_Alignment=Upper Horizontal_Extent_Factor=5 Vertical_Extent_Factor=3 PEC_Launch_Width=0.28mm} Type=EdgePort OrderId=2
setups:
  HFSS Setup 1: SolveSetupType=HFSS PercentRefinementPerPass=30 MinNumberOfPasses=1 MinNumberOfConvergedPasses=1 Frequency=10GHz MeshSizeFactor=1.5 ViaNumSides=6 ViaMaterial=copper Style25DVia=Mesh
    sweep Sweep 1: LIN 2.2GHz 2.6GHz 0.001GHz; SweepSetupType=Ensemble FastSweep SAbsError=0.005 ZoPercentError=1 PassivityTolerance=0.0001 MaxSolutions=250 InterpUseSMatrix InterpUsePortImpedance InterpUseFullBasis MagMinThreshold=0.01
    sweep Sweep 2: 2.423GHz; SweepSetupType=Ensemble GenerateSurfaceCurrent SaveRadFieldsOnly SAbsError=0.005 ZoPercentError=1 PassivityTolerance=0.0001 MaxSolutions=250 InterpUseSMatrix InterpUsePortImpedance InterpUseFullBasis MagMinThreshold=0.01
reports:
  S Parameter Plot 1: dB(S(Port1,Port1)) vs F on HFSS Setup 1 : Sweep 1; dB(S(Port1,Port1)) vs F; markers m1 at 2.38GHz, m2 at 2.37GHz, m5 at 2.423GHz, m6 at 2.4248GHz
  Gain Plot 1: dB(GainInput) vs Phi, Theta on HFSS Setup 1 : Sweep 2 [F=2.43GHz]
  S Parameter Chart 1: S(Port1,Port1) on HFSS Setup 1 : Sweep 1 [F=all]; markers m1 at 2.38GHz
  Z Parameter Plot 1: re(Z(Port1,Port1)), im(Z(Port1,Port1)) vs F on HFSS Setup 1 : Sweep 1; markers m1 at 2.43GHz, m2 at 2.43GHz
  Gain Plot 2_1: Measured vs Theta; dB(GainInput) vs Theta on HFSS Setup 1 : Sweep 2 [Phi=90deg F=2.423GHz]
  S Parameter Plot 3: dB(S(Port1,Port1)) vs F on HFSS Setup 1 : Sweep 2 [L=28.45mm]

design Circuit1 (Circuit)
options: SParamCircuitDef IntegrationMethod=FFT
components:
  S3 = LEO()
  port Port1 pnum=1 rz=50ohm iz=0ohm
nets:
  Port1: S3.0
setups:
  LinearFrequency: LinearFrequencyData(false, 0.1, false, "", false) SweepDefinition{Variable=F Data="LINC 2.2GHz 2.6GHz 1001"}
reports:
  S Parameter Plot 1: dB(S(Port1,Port1)) vs F on LinearFrequency : LinearFrequency; markers m1 at 2.4248GHz
