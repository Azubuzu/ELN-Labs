# Ansys Electronics Desktop project, version 2017.1
materials:
  copper: permeability=0.999991 conductivity=58000000

design ex3 (Circuit)
options: SParamCircuitDef IntegrationMethod=FFT
components:
  C1 = CAP_(C=4.065e-012farad)
  L2 = IND_(L=2.61e-008)
  A5 = NXRJX(RZ=0ohm IZ=-40ohm)
  A6 = NXRJX(IZ=125ohm RZ=0ohm)
  U8 = Circuit1()
  port Port1 pnum=1 rz=30ohm iz=0ohm noisetemp=16.85 noisetemporig=16.85cel
  port Port2 pnum=2 rz=125ohm iz=0ohm noisetemp=16.85 noisetemporig=16.85cel
nets:
  0: L2.1
  net_3: C1.0, A5.1
  net_4: C1.1, A6.0, L2.0
  Port1: A5.0
  Port2: A6.1
setups:
  LinearFrequency: LinearFrequencyData(false, 0.1, false, "", false) SweepDefinition{Variable=F Data="LINC 600MHz 1GHz 1000"}
reports:
  S Parameter Plot 1: re(S(Port2,Port1)), im(S(Port2,Port1)), dB(S(Port2,Port1)) vs F on LinearFrequency : LinearFrequency
  S Parameter Chart 1: S(Port2,Port1) on LinearFrequency : LinearFrequency [F=all]
  S-Parameters: S(Port1,Port1) on LinearFrequency : LinearFrequency [F=all]

design Circuit1 (Circuit)
options: SParamCircuitDef IntegrationMethod=FFT
components:
  L9 = IND_(L=27.45nH)
  C10 = CAP_(C=4.04pF)
  port Port1 pnum=1 rz=50ohm iz=0ohm
  port Port2 pnum=2 rz=50ohm iz=0ohm
nets:
  0: L9.1
  Port1: L9.0, C10.0
  Port2: C10.1

design ex4 (Circuit)
options: SParamCircuitDef IntegrationMethod=FFT
variables:
  L1 = 20deg
  C1 = 5pF
  L2 = 92deg
components:
  A14 = NXRJX(RZ=0ohm IZ=-80ohm)
  A15 = NXRJX(RZ=0ohm IZ=10ohm)
  C16 = CAP_(C=C1)
  A17 = MS_TRLE(F=1.5GHz E=L2 W=2.794mm)
  A1 = MS_TRLE(F=1.5GHz E=L1 W=2.794mm)
  port Port1 pnum=1 rz=60ohm iz=0ohm noisetemp=16.85 noisetemporig=16.85cel
  port Port2 pnum=2 rz=30ohm iz=0ohm noisetemp=16.85 noisetemporig=16.85cel
  port Port3 pnum=3 rz=50ohm iz=0ohm
nets:
  0: C16.0
  net_8: A15.0, A1.1
  net_9: C16.1, A17.1, A1.0
  Port1: A14.0
  Port2: A15.1
  Port3: A17.0
setups:
  LinearFrequency: LinearFrequencyData(false, 0.1, false, "", false) SweepDefinition{Variable=F Data="LINC 600MHz 1GHz 1000 LINC 1GHz 2GHz 1000"}
reports:
  S Parameter Plot 1: re(S(Port1,Port1)), im(S(Port1,Port1)) vs F on LinearFrequency : LinearFrequency
  S Parameter Chart 1: S(Port3,Port3) on LinearFrequency : LinearFrequency [F=all]; markers m1 at 1.5GHz, m2 at 1.5GHz, m3 at 1.5GHz, m4 at 1.5GHz, m5 at 1.5GHz
  S Parameter Plot 2: dB(S(Port1,Port1)) vs F on LinearFrequency : LinearFrequency
