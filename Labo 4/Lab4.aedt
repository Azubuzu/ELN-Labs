# Ansys Electronics Desktop project, version 2017.1
project variables:
  $w0 = 0.654mm
  $w1 = 0.549mm
  $s = 0.047mm
  $lambdaSur4 = 1mm
  $w2 = 0.7745*$w0
  $lamdaSur4 = 17.24mm
materials:
  copper: permeability=0.999991 conductivity=58000000
  FR4_epoxy: permittivity=4.4 dielectric_loss_tangent=0.02
  pec: conductivity=1e+030
  vacuum: permittivity=1
  air: permittivity=1.0006 permeability=1.0000004

design Wilkinson (HFSS 3D Layout)
ports:
  Port1: Properties{Reference=GND Impedance=50ohm Magnitude=1V Phase=0deg PostProcess Renormalize="50ohm + 0i ohm" Deembed=0mm Type="Single Strip Gap Source" HFSS_Type=Gap Orientation=Vertical Layer_Alignment=Lower Horizontal_Extent_Factor=5 Vertical_Extent_Factor=3 PEC_Launch_Width=0.06mm} Type=EdgePort OrderId=29
  Port2: Properties{Reference=GND Impedance=50ohm Magnitude=1V Phase=0deg PostProcess Renormalize="50ohm + 0i ohm" Deembed=0mm Type="Single Strip Gap Source" HFSS_Type=Gap Orientation=Vertical Layer_Alignment=Lower Horizontal_Extent_Factor=5 Vertical_Extent_Factor=3 PEC_Launch_Width=0.05mm} Type=EdgePort OrderId=30
  Port3: Properties{Reference=GND Impedance=50ohm Magnitude=1V Phase=0deg PostProcess Renormalize="50ohm + 0i ohm" Deembed=0mm Type="Single Strip Gap Source" HFSS_Type=Gap Orientation=Vertical Layer_Alignment=Lower Horizontal_Extent_Factor=5 Vertical_Extent_Factor=3 PEC_Launch_Width=0.05mm} Type=EdgePort OrderId=31
boundaries:
  Port4: Properties{Impedance=50ohm Magnitude=1V Phase=0deg PostProcess Renormalize="50ohm + 0i ohm" Deembed=0mm Type="Single Strip Gap Source Differential InternalPort1" HFSS_Type=Gap Orientation=Horizontal Layer_Alignment=Lower Horizontal_Extent_Factor=5 Vertical_Extent_Factor=3 PEC_Launch_Width=0.06mm} Type=EdgePort RLCBnd{LoadType=RLCp Properties{_R=100ohm _L=0nH _C=0pF _Real=0ohm _Imag=0ohm _Magnitude=1V _Phase=0deg _Impedance=50ohm}} OrderId=46

design DirCoup (HFSS 3D Layout)
variables:
  w1 = 0
ports:
  Port1: Properties{Reference=GND Impedance=50ohm Magnitude=1V Phase=0deg PostProcess Renormalize="50ohm + 0i ohm" Deembed=0mm Type="Single Strip Gap Source" HFSS_Type=Gap Orientation=Vertical Layer_Alignment=Lower Horizontal_Extent_Factor=5 Vertical_Extent_Factor=3 PEC_Launch_Width=0.05mm} Type=EdgePort OrderId=6
  Port2: Properties{Reference=GND Impedance=50ohm Magnitude=1V Phase=0deg PostProcess Renormalize="50ohm + 0i ohm" Deembed=0mm Type="Single Strip Gap Source" HFSS_Type=Gap Orientation=Vertical Layer_Alignment=Lower Horizontal_Extent_Factor=5 Vertical_Extent_Factor=3 PEC_Launch_Width=0.05mm} Type=EdgePort OrderId=7
  Port3: Properties{Reference=GND Impedance=50ohm Magnitude=1V Phase=0deg PostProcess Renormalize="50ohm + 0i ohm" Deembed=0mm Type="Single Strip Gap Source" HFSS_Type=Gap Orientation=Vertical Layer_Alignment=Lower Horizontal_Extent_Factor=5 Vertical_Extent_Factor=3 PEC_Launch_Width=0.05mm} Type=EdgePort OrderId=8
  Port4: Properties{Reference=GND Impedance=50ohm Magnitude=1V Phase=0deg PostProcess Renormalize="50ohm + 0i ohm" Deembed=0mm Type="Single Strip Gap Source" HFSS_Type=Gap Orientation=Vertical Layer_Alignment=Lower Horizontal_Extent_Factor=5 Vertical_Extent_Factor=3 PEC_Launch_Width=0.05mm} Type=EdgePort OrderId=9
setups:
  HFSS Setup 1: SolveSetupType=HFSS PercentRefinementPerPass=30 MinNumberOfPasses=1 MinNumberOfConvergedPasses=1 Frequency=10GHz MeshSizeFactor=1.5 ViaNumSides=6 ViaMaterial=copper Style25DVia=Mesh
    sweep Sweep 1: LIN 2GHz 3GHz 0.01GHz; SweepSetupType=Ensemble FastSweep SAbsError=0.005 ZoPercentError=1 PassivityTolerance=0.0001 MaxSolutions=250 InterpUseSMatrix InterpUsePortImpedance InterpUseFullBasis MagMinThreshold=0.01
reports:
  S Parameter Plot 1: dB(S(Port3,Port1)), -(dB(S(Port3,Port1))-dB(S(Port4,Port1))) vs F on HFSS Setup 1 : Sweep 1
